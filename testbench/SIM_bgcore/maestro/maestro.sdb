ADE simulation setup
Run mode: Single Run, Sweeps and Corners
Tests:
  edtest00_SIM_bgcore_1: edtest00/SIM_bgcore/schematic, simulator spectre
    Variables: wireopt = 9; vdda = 1.8
    Outputs: Vref @ room
Global variables:
  wireopt = 9
Corners:
  model folders: $SPECTRE_MODEL_PATH
  FF: 12LP_Spectre.lib[ff]
  SS: 12LP_Spectre.lib[ss]
