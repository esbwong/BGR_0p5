ADE simulation setup
Test edtest00_SIM_bgcore_1: edtest00/SIM_bgcore/schematic, simulator spectre
  Models: $SPECTRE_MODEL_PATH/12LP_Spectre.lib[tt]
  Variables: vdda = 1.8; wireopt = 9
  Temperature: 27
  Analysis stb: start=1 stop=1e9 probe=/Ibg/V0 stbProbeMode=single-ended
  Analysis dc: sweep temperature start=-40 stop=125 (saves the operating point)
  Output Vref @ room = value(VS("/vref") 27)
  Output vref max = ymax(VS("/vref"))
  Output vref min = ymin(VS("/vref"))
  Output PM = getData("/phaseMargin" ?result "stb_margin")
  Output UGF = getData("/phaseMarginFreq" ?result "stb_margin")
  Output DCG = ymax(db(mag(getData("loopGain" ?result "stb"))))
  Output Loop Gain dB20 = db(mag(getData("loopGain" ?result "stb")))
  Output Loop Gain Phase = phaseDegUnwrapped(getData("loopGain" ?result "stb"))
  Signals: /vref, /V0/PLUS (terminal), /Ibg/vbe0, /Ibg/vbe1, /Ibg/vx
Run mode: Single Run, Sweeps and Corners
Global variables:
  wireopt = 9
Corners:
  model folders: $SPECTRE_MODEL_PATH
  FF: 12LP_Spectre.lib[ff]
  SS: 12LP_Spectre.lib[ss]
