ADE simulation setup
Test edtest00_SIM_bgcore_tran_1: edtest00/SIM_bgcore_tran/schematic, simulator spectre
  Models: $SPECTRE_MODEL_PATH/12LP_Spectre.lib[tt]
  Variables: vdda = 1.8; wireopt = 9
  Temperature: 27
  Analysis tran: stop=1.2e-3 errpreset=conservative
  Signals: /vpdn, /vref, /Ibg/vdda (terminal), /Ibg/start_done
Run mode: Single Run, Sweeps and Corners
