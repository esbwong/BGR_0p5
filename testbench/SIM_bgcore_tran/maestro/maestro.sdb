ADE simulation setup
Run mode: Single Run, Sweeps and Corners
Tests:
  edtest00_SIM_bgcore_tran_1: edtest00/SIM_bgcore_tran/schematic, simulator spectre
    Variables: wireopt = 9; vdda = 1.8
